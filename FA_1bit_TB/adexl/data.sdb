ADE simulation setup
Run mode: Single Run, Sweeps and Corners
Tests:
  FA_1BIT: EDATP/FA_1bit_TB/schematic, simulator spectre
Global variables:
  Tp = 10n
  VDD = 1.8
  Tsim = 10*Tp
  a = 2
  b = 1
  W = 440n
