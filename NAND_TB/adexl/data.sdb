ADE simulation setup
Run mode: Single Run, Sweeps and Corners
Tests:
  NAND_Transient: EDATP/NAND_TB/schematic, simulator spectre
    Outputs: InputB
Global variables:
  VDD = 1.8
  Period = 5ns
  Tsim = 4*Period
