ADE simulation setup
Run mode: Single Run, Sweeps and Corners
Tests:
  LOGIC_1BIT: EDATP/LOGIC_1bit_TB/schematic, simulator spectre
Global variables:
  Tp = 5n
  VDD = 1.8
  Tsim = 10*Tp
