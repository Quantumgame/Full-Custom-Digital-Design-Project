ADE simulation setup
Run mode: Single Run, Sweeps and Corners
Tests:
  Transient: EDATP/Inverter_TB/schematic, simulator spectre
Global variables:
  Period = 2n
  VDD = 1.8
  Tsim = 4*Period
  sigma = 3
Corners:
  model folders: /home/edabd6/edabd2017_fullcust/CDS_VISO/Models/Spectre/Monte_Carlo
  FF: temperature=80; VDD=1.5; mm180_reg18_v124_mc_corner.lib.scs[ff]
  SS: temperature=80; VDD=1.5; mm180_reg18_v124_mc_corner.lib.scs[ss]
  FS: temperature=80; VDD=1.5; mm180_reg18_v124_mc_corner.lib.scs[fnsp]
  SF: temperature=80; VDD=1.5; mm180_reg18_v124_mc_corner.lib.scs[snfp]
Specs:
  Transient / delay(?wf1 VT("/IN") ?value1 0.9 ?edge1 "rising" ?nth1 1 ?td1 0.0 ?wf2 VT("/OUT") ?value2 0.9 ?edge2 "falling" ?nth2 1 ?td2 0.0 ?stop nil ?multiple nil): < 100p
  Transient / delay(?wf1 VT("/IN") ?value1 0.9 ?edge1 "falling" ?nth1 1 ?td1 0.0 ?wf2 VT("/OUT") ?value2 0.9 ?edge2 "rising" ?nth2 1 ?td2 0.0 ?stop nil ?multiple nil): < 100p
