ADE simulation setup
Run mode: Single Run, Sweeps and Corners
Tests:
  EDATP:ALU_8bit_TB:1: EDATP/ALU_8bit_TB/schematic, simulator spectre
    Outputs: B<0>; delay(?wf1 VT("/A") ?value1 0.9 ?edge1 "falling" ?nth1 1 ?td1 0.0 ?wf2 VT("/X") ?value2 0.9 ?edge2 "rising" ?nth2 1 ?td2 0.0 ?stop nil ?multiple nil); delay(?wf1 VT("/B<0>") ?value1 0.9 ?edge1 "falling" ?nth1 1 ?td1 0.0 ?wf2 VT("/Z<0>") ?value2 0.9 ?edge2 "rising" ?nth2 1 ?td2 0.0 ?stop nil ?multiple nil); delay(?wf1 VT("/B<0>") ?value1 0.9 ?edge1 "rising" ?nth1 1 ?td1 0.0 ?wf2 VT("/Z<0>") ?value2 0.9 ?edge2 "falling" ?nth2 1 ?td2 0.0 ?stop nil ?multiple nil); delay(?wf1 VT("/B<0>") ?value1 0.9 ?edge1 "falling" ?nth1 2 ?td1 0.0 ?wf2 VT("/Z<0>") ?value2 0.9 ?edge2 "rising" ?nth2 1 ?td2 0.0 ?stop nil ?multiple nil); delay(?wf1 VT("/B<0>") ?value1 0.9 ?edge1 "falling" ?nth1 3 ?td1 0.0 ?wf2 VT("/Z<0>") ?value2 0.9 ?edge2 "rising" ?nth2 1 ?td2 0.0 ?stop nil ?multiple nil); Delay_R; Delay_F
Global variables:
  VDD = 1.8
  Tp = 5n
  a = 4
  W = 440n
  b = 2
  c = 4
  d = 2
