ADE simulation setup
Run mode: Single Run, Sweeps and Corners
Tests:
  EDATP:LOGIC_8bit_TB:1: EDATP/LOGIC_8bit_TB/schematic, simulator spectre
Global variables:
  Tp = 10n
  VDD = 1.8
  Tsim = 10*Tp
